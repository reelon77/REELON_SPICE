V1 in 0 2
R1 in out 2
C1 out 0 500m
.tran 250m 500m
.end
